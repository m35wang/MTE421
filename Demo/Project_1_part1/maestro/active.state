ADE simulation setup
Test Demo_Project_1_part1_1: Demo/Project_1_part1/schematic, simulator spectre
  Models: /CMC/kits/GPDK45/gpdk045_v_6_0/gpdk045/../models/spectre/gpdk045.scs[mc]
  Variables: vdc = 0.0; vin = 0
  Temperature: 27
  Analysis dc: (saves the operating point)
  Signals: /VIN, /NM0/D (terminal)
Run mode: Single Run, Sweeps and Corners
Setup values for test Demo_Project_1_part1_1: vdc = 0:0.1:1
