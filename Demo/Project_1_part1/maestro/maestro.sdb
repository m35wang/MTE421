ADE simulation setup
Run mode: Single Run, Sweeps and Corners
Tests:
  Demo_Project_1_part1_1: Demo/Project_1_part1/schematic, simulator spectre
    Variables: vdc = 0:0.1:1; vin = 0
    Outputs: /VIN
