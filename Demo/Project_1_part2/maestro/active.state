ADE simulation setup
Test Demo_Project_1_part2_1: Demo/Project_1_part2/schematic, simulator spectre
  Models: /CMC/kits/GPDK45/gpdk045_v_6_0/gpdk045/../models/spectre/gpdk045.scs[mc]
  Variables: VDD = 2; vin = 1; vin_ac = 1m
  Temperature: 27
  Analysis ac: start=100M stop=100G
  Signals: /I8/noConn (terminal), /I7/noConn (terminal)
Run mode: Single Run, Sweeps and Corners
