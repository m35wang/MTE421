ADE simulation setup
Run mode: Single Run, Sweeps and Corners
Tests:
  Demo_Project_1_part2_1: Demo/Project_1_part2/schematic, simulator spectre
    Variables: VDD = 2; vin = 1; vin_ac = 1m
